// simulation setup for SL_nand2
// stimuli: VDD = 1.2V, V0 = pulse, V1 = high
// test type: 50ns transient simulation
simulator lang=spectre
VDD (vdd 0) vsource dc=1.2
GND (vss 0) vsource dc=0
V0 (in0 0) vsource type=pulse val0=0 val1=1.2 delay=0 rise=0.05n fall=0.05n width=10n period=20n
V1 (in1 0) vsource dc=1.2
test1 tran stop=50n maxiters=5
