// simulation setup for SL_nand2
simulator lang=spectre
VDD (vdd 0) vsource dc=1.2
GND (vss 0) vsource dc=0
V0 (in0 0) vsource dc=1.2
V1 (in1 0) vsource dc=1.2

// current source mimic ion collision on MN0
STRIKE (out net13) isource type=pulse val0=0 val1=300u period=50n rise=5p fall=5p width=1p

// transient sim for 100 ps
sim tran stop=100p
