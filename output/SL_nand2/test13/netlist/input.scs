// Design: MAINLIB_TESTING/SL_nand2
simulator lang=spectre
global 0
include "design_wrapper.lib" section=tt_fet
include "design_wrapper.lib" section=tt_rc
include "design_wrapper.lib" section=tt_parRC
include "design_wrapper.lib" section=tt_cell
include "design_wrapper.lib" section=models

// MAINLIB_TESTING/SL_nand2/schematic
MN1 (net13 in1 vss vss) nshort l=0.2 w=0.5 m=1 mult=1
MN0 (out in0 net13 net13) nshort l=0.2 w=0.5 m=1 mult=1
MP1 (out in1 vdd vdd) pshort l=0.2 w=0.4 m=1 mult=1
MP0 (out in0 vdd vdd) pshort l=0.2 w=0.4 m=1 mult=1
simulatorOptions options temp=27

// simulation setup for SL_nand2
simulator lang=spectre
VDD (vdd 0) vsource dc=1.2
GND (vss 0) vsource dc=0
V0 (in0 0) vsource dc=1.2
V1 (in1 0) vsource dc=1.2

// current source mimic ion collision on MN0
STRIKE (out net13) isource type=pulse val0=0 val1=300u period=50n rise=5p fall=5p width=1p

// transient sim for 100 ps
sim tran stop=100p
