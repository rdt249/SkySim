// Design: MAINLIB_TESTING/SL_inv_1x
simulator lang=spectre
global 0
include "design_wrapper.lib" section=tt_fet
include "design_wrapper.lib" section=tt_rc
include "design_wrapper.lib" section=tt_parRC
include "design_wrapper.lib" section=tt_cell
include "design_wrapper.lib" section=models

// MAINLIB_TESTING/SL_inv_1x/schematic
MP0 (out in vdd vdd) pshort l=0.1 w=0.734 m=1 mult=1
MN0 (out in vss vss) nshort l=0.1 w=0.28 m=1 mult=1
simulatorOptions options temp=27

// simulation setup for SL_inv_1x
simulator lang=spectre
VDD (vdd 0) vsource dc=1.2
GND (vss 0) vsource dc=0
V0 (in 0) vsource dc=1.2

// current source mimic ion collision on MN0
STRIKE (out vss) isource type=pulse val0=0 val1=1m period=50n width=5p rise=1p fall=5p

// transient sim for 100ps
sim tran stop=100p
