// Design: MAINLIB_TESTING/SL_nand2
simulator lang=spectre
global 0
include "design_wrapper.lib" section=tt_fet
include "design_wrapper.lib" section=tt_rc
include "design_wrapper.lib" section=tt_parRC
include "design_wrapper.lib" section=tt_cell
include "design_wrapper.lib" section=models

// MAINLIB_TESTING/SL_nand2/schematic
MN1 (net13 in1 vss vss) nshort l=0.2 w=0.5 m=1 mult=1
MN0 (out in0 net13 net13) nshort l=0.2 w=0.5 m=1 mult=1
MP1 (out in1 vdd vdd) pshort l=0.2 w=0.4 m=1 mult=1
MP0 (out in0 vdd vdd) pshort l=0.2 w=0.4 m=1 mult=1
include "/home/lawrence/simulation/MAINLIB_TESTING/SL_nand2/adexl/results/data/.tmpADEDir_lawrence/MAINLIB_TESTING:SL_nand2:1/MAINLIB_TESTING_SL_nand2_schematic_spectre/netlist/stimuli/job0.txt"
simulatorOptions options temp=27
tran tran stop=50n
