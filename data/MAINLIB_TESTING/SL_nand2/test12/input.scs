// Design: MAINLIB_TESTING/SL_nand2
simulator lang=spectre
global 0
include "design_wrapper.lib" section=tt_fet
include "design_wrapper.lib" section=tt_rc
include "design_wrapper.lib" section=tt_parRC
include "design_wrapper.lib" section=tt_cell
include "design_wrapper.lib" section=models

// MAINLIB_TESTING/SL_nand2/schematic
MN1 (net13 in1 vss vss) nshort l=0.2 w=0.5 m=1 mult=1
MN0 (out in0 net13 net13) nshort l=0.2 w=0.5 m=1 mult=1
MP1 (out in1 vdd vdd) pshort l=0.2 w=0.4 m=1 mult=1
MP0 (out in0 vdd vdd) pshort l=0.2 w=0.4 m=1 mult=1
simulatorOptions options temp=27

// SkySim test0
// target device: MN1
VSS (vss 0) vsource dc=0
V0 (in1 0) vsource dc=1.2
V1 (in0 0) vsource dc=1.2
VDD (vdd 0) vsource dc=1.2
STRIKE (net13 vss) isource type=pulse val0=0 val1=200u period=100n width=5p rise=1p fall=5p
sim tran stop=100p
